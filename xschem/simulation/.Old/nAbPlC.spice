** sch_path: /home/ttuser/nAbPlC/nAbPlC.sch
.subckt nAbPlC aOp bOp cOp vdd yOut vss
*.PININFO aOp:I bOp:I cOp:I vdd:I vss:I yOut:O
XM1 ab_c aOp vdd sky130_fd_pr__pfet_01v8 L=0.15 W=1 nf=1 m=1
XM2 ab_c bOp vdd sky130_fd_pr__pfet_01v8 L=0.15 W=1 nf=1 m=1
XM3 yOut cOp ab_c sky130_fd_pr__pfet_01v8 L=0.15 W=1 nf=1 m=1
XM4 yOut aOp a_b sky130_fd_pr__nfet_01v8 L=0.15 W=1 nf=1 m=1
XM5 a_b bOp vss sky130_fd_pr__nfet_01v8 L=0.15 W=1 nf=1 m=1
XM6 yOut cOp vss sky130_fd_pr__nfet_01v8 L=0.15 W=1 nf=1 m=1
.ends
.end
