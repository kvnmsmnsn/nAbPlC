** sch_path: /home/ttuser/nAbPlC/xschem/tb_nAbPlC.sch
**.subckt tb_nAbPlC bIn aIn cIn bIn aIn cIn
*.ipin bIn
*.ipin aIn
*.ipin cIn
*.ipin bIn
*.ipin aIn
*.ipin cIn
R1 rslt yOt 1k m=1
C1 rslt GND 1p m=1
V1 net2 GND 1.8
V2 net1 GND 0
x1 aIn bIn cIn net2 yOt net1 nAbPlC
R2 rslt_parax yOt_p 1k m=1
C2 rslt_parax GND 1p m=1
V3 net4 GND 1.8
V4 net3 GND 0
x2 aIn bIn cIn net4 yOt_p net3 nAbPlC_parax
**** begin user architecture code

** opencircuitdesign pdks install
.lib /home/ttuser/pdk/sky130A/libs.tech/ngspice/sky130.lib.spice tt

* .lib /home/ttuser/pdk/sky130A/libs.tech/ngspice/sky130.lib.spice tt
vA aIn 0 pulse 0 1.8 5n 1n 1n 400n 800n
vB bIn 0 pulse 0 1.8 5n 1n 1n 200n 400n
vC cIn 0 pulse 0 1.8 5n 1n 1n 100n 200n
.control
tran 100p 800n
write tb_nAbPlC.raw
.endc

**** end user architecture code
**.ends

* expanding   symbol:  nAbPlC.sym # of pins=6
** sym_path: /home/ttuser/nAbPlC/xschem/nAbPlC.sym
** sch_path: /home/ttuser/nAbPlC/xschem/nAbPlC.sch
.subckt nAbPlC aOp bOp cOp vdd yOut vss
*.ipin aOp
*.ipin bOp
*.ipin cOp
*.ipin vdd
*.ipin vss
*.opin yOut
XM7 ab_c aOp vdd vdd sky130_fd_pr__pfet_01v8 L=0.15 W=1 nf=1 ad='int((nf+1)/2) * W/nf * 0.29' as='int((nf+2)/2) * W/nf * 0.29' pd='2*int((nf+1)/2) * (W/nf + 0.29)'
+ ps='2*int((nf+2)/2) * (W/nf + 0.29)' nrd='0.29 / W' nrs='0.29 / W' sa=0 sb=0 sd=0 mult=1 m=1
XM8 ab_c bOp vdd vdd sky130_fd_pr__pfet_01v8 L=0.15 W=1 nf=1 ad='int((nf+1)/2) * W/nf * 0.29' as='int((nf+2)/2) * W/nf * 0.29' pd='2*int((nf+1)/2) * (W/nf + 0.29)'
+ ps='2*int((nf+2)/2) * (W/nf + 0.29)' nrd='0.29 / W' nrs='0.29 / W' sa=0 sb=0 sd=0 mult=1 m=1
XM9 yOut cOp ab_c vdd sky130_fd_pr__pfet_01v8 L=0.15 W=1 nf=1 ad='int((nf+1)/2) * W/nf * 0.29' as='int((nf+2)/2) * W/nf * 0.29' pd='2*int((nf+1)/2) * (W/nf + 0.29)'
+ ps='2*int((nf+2)/2) * (W/nf + 0.29)' nrd='0.29 / W' nrs='0.29 / W' sa=0 sb=0 sd=0 mult=1 m=1
XM10 yOut aOp a_b vss sky130_fd_pr__nfet_01v8 L=0.15 W=1 nf=1 ad='int((nf+1)/2) * W/nf * 0.29' as='int((nf+2)/2) * W/nf * 0.29' pd='2*int((nf+1)/2) * (W/nf + 0.29)'
+ ps='2*int((nf+2)/2) * (W/nf + 0.29)' nrd='0.29 / W' nrs='0.29 / W' sa=0 sb=0 sd=0 mult=1 m=1
XM11 a_b bOp vss vss sky130_fd_pr__nfet_01v8 L=0.15 W=1 nf=1 ad='int((nf+1)/2) * W/nf * 0.29' as='int((nf+2)/2) * W/nf * 0.29' pd='2*int((nf+1)/2) * (W/nf + 0.29)'
+ ps='2*int((nf+2)/2) * (W/nf + 0.29)' nrd='0.29 / W' nrs='0.29 / W' sa=0 sb=0 sd=0 mult=1 m=1
XM12 yOut cOp vss vss sky130_fd_pr__nfet_01v8 L=0.15 W=1 nf=1 ad='int((nf+1)/2) * W/nf * 0.29' as='int((nf+2)/2) * W/nf * 0.29' pd='2*int((nf+1)/2) * (W/nf + 0.29)'
+ ps='2*int((nf+2)/2) * (W/nf + 0.29)' nrd='0.29 / W' nrs='0.29 / W' sa=0 sb=0 sd=0 mult=1 m=1
.ends

* expanding   symbol:  nAbPlC_parax.sym # of pins=6
** sym_path: /home/ttuser/nAbPlC/xschem/nAbPlC.sym
.include /home/ttuser/nAbPlC/mag/nAbPlC.sim.spice
.GLOBAL GND
.end
