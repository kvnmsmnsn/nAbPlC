** sch_path: /home/ttuser/nAbPlC/xschem/nAbPlC.sch
.subckt nAbPlC aOp bOp cOp vdd yOut vss
*.PININFO aOp:I bOp:I cOp:I vdd:I vss:I yOut:O
XM7 ab_c aOp vdd vdd sky130_fd_pr__pfet_01v8 L=0.15 W=1 nf=1 m=1
XM8 ab_c bOp vdd vdd sky130_fd_pr__pfet_01v8 L=0.15 W=1 nf=1 m=1
XM9 yOut cOp ab_c vdd sky130_fd_pr__pfet_01v8 L=0.15 W=1 nf=1 m=1
XM10 yOut aOp a_b vss sky130_fd_pr__nfet_01v8 L=0.15 W=1 nf=1 m=1
XM11 a_b bOp vss vss sky130_fd_pr__nfet_01v8 L=0.15 W=1 nf=1 m=1
XM12 yOut cOp vss vss sky130_fd_pr__nfet_01v8 L=0.15 W=1 nf=1 m=1
.ends
.end
